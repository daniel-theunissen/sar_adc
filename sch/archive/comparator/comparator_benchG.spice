** Bench G: the Fig. 15 comparator on its own, driven through the node impedance of the summing stage.
** Needs comparator.spice (or your own subcircuit with the same pins) in the same folder. 250 cycles of 100 ns (full plan), corner tt, 27 C.
** Cycle k starts at k*100 ns: reset (phi1 LOW = T9 on, phi2 HIGH = NMOS latch off and Q = Qb = 0), the inputs step at +2 ns,
**   phi1 rises at +70 ns (release, PMOS latch regenerates), phi2 falls at +72 ns (gap 2 ns, NMOS latch connected),
**   at the end of the cycle phi2 rises at 100 ns and phi1 falls 0.3 ns later (reset again, the decision is lost on Q/Qb).
** Groups: A = overdrive 0.1..100 mV both signs; B = common mode 0.6..1.3 V at +/-5 mV and +/-1 mV (full plan only); C = offset ramp, up then down.
** An SR latch (two NOR gates) on Q/Qb holds the decision through the reset: outputs vlat / vlatb.
** Generated by make_benchG.py.
.include comparator.spice

.param rsrc=35000 cin=9.5e-14 cout=1e-14
Vdd VDD 0 1.8
* clocks. phi1: LOW = reset. phi2: HIGH = reset (NMOS latch off, connect switches off); LOW = connected
Vphi1 phi1 0 pulse(0 1.8 70n 0.1n 0.1n 30.2n 100n)
Vphi2 phi2 0 pulse(1.8 0 72n 0.1n 0.1n 27.9n 100n)
* ideal differential sources, then the node impedance of the summing stage
Vsp sp 0 pwl( 0.0n 0.9490500 102.0n 0.9490500 102.1n 0.9489500 202.0n 0.9489500 202.1n 0.9491000 302.0n 0.9491000
+ 302.1n 0.9489000 402.0n 0.9489000 402.1n 0.9492500 502.0n 0.9492500 502.1n 0.9487500
+ 602.0n 0.9487500 602.1n 0.9495000 702.0n 0.9495000 702.1n 0.9485000 802.0n 0.9485000
+ 802.1n 0.9500000 902.0n 0.9500000 902.1n 0.9480000 1002.0n 0.9480000 1002.1n 0.9515000
+ 1102.0n 0.9515000 1102.1n 0.9465000 1202.0n 0.9465000 1202.1n 0.9540000 1302.0n 0.9540000
+ 1302.1n 0.9440000 1402.0n 0.9440000 1402.1n 0.9590000 1502.0n 0.9590000 1502.1n 0.9390000
+ 1602.0n 0.9390000 1602.1n 0.9740000 1702.0n 0.9740000 1702.1n 0.9240000 1802.0n 0.9240000
+ 1802.1n 0.9990000 1902.0n 0.9990000 1902.1n 0.8990000 2002.0n 0.8990000 2002.1n 0.6025000
+ 2102.0n 0.6025000 2102.1n 0.5975000 2202.0n 0.5975000 2202.1n 0.6005000 2302.0n 0.6005000
+ 2302.1n 0.5995000 2402.0n 0.5995000 2402.1n 0.7025000 2502.0n 0.7025000 2502.1n 0.6975000
+ 2602.0n 0.6975000 2602.1n 0.7005000 2702.0n 0.7005000 2702.1n 0.6995000 2802.0n 0.6995000
+ 2802.1n 0.8025000 2902.0n 0.8025000 2902.1n 0.7975000 3002.0n 0.7975000 3002.1n 0.8005000
+ 3102.0n 0.8005000 3102.1n 0.7995000 3202.0n 0.7995000 3202.1n 0.9025000 3302.0n 0.9025000
+ 3302.1n 0.8975000 3402.0n 0.8975000 3402.1n 0.9005000 3502.0n 0.9005000 3502.1n 0.8995000
+ 3602.0n 0.8995000 3602.1n 0.9515000 3702.0n 0.9515000 3702.1n 0.9465000 3802.0n 0.9465000
+ 3802.1n 0.9495000 3902.0n 0.9495000 3902.1n 0.9485000 4002.0n 0.9485000 4002.1n 1.0025000
+ 4102.0n 1.0025000 4102.1n 0.9975000 4202.0n 0.9975000 4202.1n 1.0005000 4302.0n 1.0005000
+ 4302.1n 0.9995000 4402.0n 0.9995000 4402.1n 1.1025000 4502.0n 1.1025000 4502.1n 1.0975000
+ 4602.0n 1.0975000 4602.1n 1.1005000 4702.0n 1.1005000 4702.1n 1.0995000 4802.0n 1.0995000
+ 4802.1n 1.2025000 4902.0n 1.2025000 4902.1n 1.1975000 5002.0n 1.1975000 5002.1n 1.2005000
+ 5102.0n 1.2005000 5102.1n 1.1995000 5202.0n 1.1995000 5202.1n 1.3025000 5302.0n 1.3025000
+ 5302.1n 1.2975000 5402.0n 1.2975000 5402.1n 1.3005000 5502.0n 1.3005000 5502.1n 1.2995000
+ 5602.0n 1.2995000 5602.1n 0.9430000 5702.0n 0.9430000 5702.1n 0.9431250 5802.0n 0.9431250
+ 5802.1n 0.9432500 5902.0n 0.9432500 5902.1n 0.9433750 6002.0n 0.9433750 6002.1n 0.9435000
+ 6102.0n 0.9435000 6102.1n 0.9436250 6202.0n 0.9436250 6202.1n 0.9437500 6302.0n 0.9437500
+ 6302.1n 0.9438750 6402.0n 0.9438750 6402.1n 0.9440000 6502.0n 0.9440000 6502.1n 0.9441250
+ 6602.0n 0.9441250 6602.1n 0.9442500 6702.0n 0.9442500 6702.1n 0.9443750 6802.0n 0.9443750
+ 6802.1n 0.9445000 6902.0n 0.9445000 6902.1n 0.9446250 7002.0n 0.9446250 7002.1n 0.9447500
+ 7102.0n 0.9447500 7102.1n 0.9448750 7202.0n 0.9448750 7202.1n 0.9450000 7302.0n 0.9450000
+ 7302.1n 0.9451250 7402.0n 0.9451250 7402.1n 0.9452500 7502.0n 0.9452500 7502.1n 0.9453750
+ 7602.0n 0.9453750 7602.1n 0.9455000 7702.0n 0.9455000 7702.1n 0.9456250 7802.0n 0.9456250
+ 7802.1n 0.9457500 7902.0n 0.9457500 7902.1n 0.9458750 8002.0n 0.9458750 8002.1n 0.9460000
+ 8102.0n 0.9460000 8102.1n 0.9461250 8202.0n 0.9461250 8202.1n 0.9462500 8302.0n 0.9462500
+ 8302.1n 0.9463750 8402.0n 0.9463750 8402.1n 0.9465000 8502.0n 0.9465000 8502.1n 0.9466250
+ 8602.0n 0.9466250 8602.1n 0.9467500 8702.0n 0.9467500 8702.1n 0.9468750 8802.0n 0.9468750
+ 8802.1n 0.9470000 8902.0n 0.9470000 8902.1n 0.9471250 9002.0n 0.9471250 9002.1n 0.9472500
+ 9102.0n 0.9472500 9102.1n 0.9473750 9202.0n 0.9473750 9202.1n 0.9475000 9302.0n 0.9475000
+ 9302.1n 0.9476250 9402.0n 0.9476250 9402.1n 0.9477500 9502.0n 0.9477500 9502.1n 0.9478750
+ 9602.0n 0.9478750 9602.1n 0.9480000 9702.0n 0.9480000 9702.1n 0.9481250 9802.0n 0.9481250
+ 9802.1n 0.9482500 9902.0n 0.9482500 9902.1n 0.9483750 10002.0n 0.9483750 10002.1n 0.9485000
+ 10102.0n 0.9485000 10102.1n 0.9486250 10202.0n 0.9486250 10202.1n 0.9487500 10302.0n 0.9487500
+ 10302.1n 0.9488750 10402.0n 0.9488750 10402.1n 0.9490000 10502.0n 0.9490000 10502.1n 0.9491250
+ 10602.0n 0.9491250 10602.1n 0.9492500 10702.0n 0.9492500 10702.1n 0.9493750 10802.0n 0.9493750
+ 10802.1n 0.9495000 10902.0n 0.9495000 10902.1n 0.9496250 11002.0n 0.9496250 11002.1n 0.9497500
+ 11102.0n 0.9497500 11102.1n 0.9498750 11202.0n 0.9498750 11202.1n 0.9500000 11302.0n 0.9500000
+ 11302.1n 0.9501250 11402.0n 0.9501250 11402.1n 0.9502500 11502.0n 0.9502500 11502.1n 0.9503750
+ 11602.0n 0.9503750 11602.1n 0.9505000 11702.0n 0.9505000 11702.1n 0.9506250 11802.0n 0.9506250
+ 11802.1n 0.9507500 11902.0n 0.9507500 11902.1n 0.9508750 12002.0n 0.9508750 12002.1n 0.9510000
+ 12102.0n 0.9510000 12102.1n 0.9511250 12202.0n 0.9511250 12202.1n 0.9512500 12302.0n 0.9512500
+ 12302.1n 0.9513750 12402.0n 0.9513750 12402.1n 0.9515000 12502.0n 0.9515000 12502.1n 0.9516250
+ 12602.0n 0.9516250 12602.1n 0.9517500 12702.0n 0.9517500 12702.1n 0.9518750 12802.0n 0.9518750
+ 12802.1n 0.9520000 12902.0n 0.9520000 12902.1n 0.9521250 13002.0n 0.9521250 13002.1n 0.9522500
+ 13102.0n 0.9522500 13102.1n 0.9523750 13202.0n 0.9523750 13202.1n 0.9525000 13302.0n 0.9525000
+ 13302.1n 0.9526250 13402.0n 0.9526250 13402.1n 0.9527500 13502.0n 0.9527500 13502.1n 0.9528750
+ 13602.0n 0.9528750 13602.1n 0.9530000 13702.0n 0.9530000 13702.1n 0.9531250 13802.0n 0.9531250
+ 13802.1n 0.9532500 13902.0n 0.9532500 13902.1n 0.9533750 14002.0n 0.9533750 14002.1n 0.9535000
+ 14102.0n 0.9535000 14102.1n 0.9536250 14202.0n 0.9536250 14202.1n 0.9537500 14302.0n 0.9537500
+ 14302.1n 0.9538750 14402.0n 0.9538750 14402.1n 0.9540000 14502.0n 0.9540000 14502.1n 0.9541250
+ 14602.0n 0.9541250 14602.1n 0.9542500 14702.0n 0.9542500 14702.1n 0.9543750 14802.0n 0.9543750
+ 14802.1n 0.9545000 14902.0n 0.9545000 14902.1n 0.9546250 15002.0n 0.9546250 15002.1n 0.9547500
+ 15102.0n 0.9547500 15102.1n 0.9548750 15202.0n 0.9548750 15202.1n 0.9550000 15302.0n 0.9550000
+ 15302.1n 0.9550000 15402.0n 0.9550000 15402.1n 0.9548750 15502.0n 0.9548750 15502.1n 0.9547500
+ 15602.0n 0.9547500 15602.1n 0.9546250 15702.0n 0.9546250 15702.1n 0.9545000 15802.0n 0.9545000
+ 15802.1n 0.9543750 15902.0n 0.9543750 15902.1n 0.9542500 16002.0n 0.9542500 16002.1n 0.9541250
+ 16102.0n 0.9541250 16102.1n 0.9540000 16202.0n 0.9540000 16202.1n 0.9538750 16302.0n 0.9538750
+ 16302.1n 0.9537500 16402.0n 0.9537500 16402.1n 0.9536250 16502.0n 0.9536250 16502.1n 0.9535000
+ 16602.0n 0.9535000 16602.1n 0.9533750 16702.0n 0.9533750 16702.1n 0.9532500 16802.0n 0.9532500
+ 16802.1n 0.9531250 16902.0n 0.9531250 16902.1n 0.9530000 17002.0n 0.9530000 17002.1n 0.9528750
+ 17102.0n 0.9528750 17102.1n 0.9527500 17202.0n 0.9527500 17202.1n 0.9526250 17302.0n 0.9526250
+ 17302.1n 0.9525000 17402.0n 0.9525000 17402.1n 0.9523750 17502.0n 0.9523750 17502.1n 0.9522500
+ 17602.0n 0.9522500 17602.1n 0.9521250 17702.0n 0.9521250 17702.1n 0.9520000 17802.0n 0.9520000
+ 17802.1n 0.9518750 17902.0n 0.9518750 17902.1n 0.9517500 18002.0n 0.9517500 18002.1n 0.9516250
+ 18102.0n 0.9516250 18102.1n 0.9515000 18202.0n 0.9515000 18202.1n 0.9513750 18302.0n 0.9513750
+ 18302.1n 0.9512500 18402.0n 0.9512500 18402.1n 0.9511250 18502.0n 0.9511250 18502.1n 0.9510000
+ 18602.0n 0.9510000 18602.1n 0.9508750 18702.0n 0.9508750 18702.1n 0.9507500 18802.0n 0.9507500
+ 18802.1n 0.9506250 18902.0n 0.9506250 18902.1n 0.9505000 19002.0n 0.9505000 19002.1n 0.9503750
+ 19102.0n 0.9503750 19102.1n 0.9502500 19202.0n 0.9502500 19202.1n 0.9501250 19302.0n 0.9501250
+ 19302.1n 0.9500000 19402.0n 0.9500000 19402.1n 0.9498750 19502.0n 0.9498750 19502.1n 0.9497500
+ 19602.0n 0.9497500 19602.1n 0.9496250 19702.0n 0.9496250 19702.1n 0.9495000 19802.0n 0.9495000
+ 19802.1n 0.9493750 19902.0n 0.9493750 19902.1n 0.9492500 20002.0n 0.9492500 20002.1n 0.9491250
+ 20102.0n 0.9491250 20102.1n 0.9490000 20202.0n 0.9490000 20202.1n 0.9488750 20302.0n 0.9488750
+ 20302.1n 0.9487500 20402.0n 0.9487500 20402.1n 0.9486250 20502.0n 0.9486250 20502.1n 0.9485000
+ 20602.0n 0.9485000 20602.1n 0.9483750 20702.0n 0.9483750 20702.1n 0.9482500 20802.0n 0.9482500
+ 20802.1n 0.9481250 20902.0n 0.9481250 20902.1n 0.9480000 21002.0n 0.9480000 21002.1n 0.9478750
+ 21102.0n 0.9478750 21102.1n 0.9477500 21202.0n 0.9477500 21202.1n 0.9476250 21302.0n 0.9476250
+ 21302.1n 0.9475000 21402.0n 0.9475000 21402.1n 0.9473750 21502.0n 0.9473750 21502.1n 0.9472500
+ 21602.0n 0.9472500 21602.1n 0.9471250 21702.0n 0.9471250 21702.1n 0.9470000 21802.0n 0.9470000
+ 21802.1n 0.9468750 21902.0n 0.9468750 21902.1n 0.9467500 22002.0n 0.9467500 22002.1n 0.9466250
+ 22102.0n 0.9466250 22102.1n 0.9465000 22202.0n 0.9465000 22202.1n 0.9463750 22302.0n 0.9463750
+ 22302.1n 0.9462500 22402.0n 0.9462500 22402.1n 0.9461250 22502.0n 0.9461250 22502.1n 0.9460000
+ 22602.0n 0.9460000 22602.1n 0.9458750 22702.0n 0.9458750 22702.1n 0.9457500 22802.0n 0.9457500
+ 22802.1n 0.9456250 22902.0n 0.9456250 22902.1n 0.9455000 23002.0n 0.9455000 23002.1n 0.9453750
+ 23102.0n 0.9453750 23102.1n 0.9452500 23202.0n 0.9452500 23202.1n 0.9451250 23302.0n 0.9451250
+ 23302.1n 0.9450000 23402.0n 0.9450000 23402.1n 0.9448750 23502.0n 0.9448750 23502.1n 0.9447500
+ 23602.0n 0.9447500 23602.1n 0.9446250 23702.0n 0.9446250 23702.1n 0.9445000 23802.0n 0.9445000
+ 23802.1n 0.9443750 23902.0n 0.9443750 23902.1n 0.9442500 24002.0n 0.9442500 24002.1n 0.9441250
+ 24102.0n 0.9441250 24102.1n 0.9440000 24202.0n 0.9440000 24202.1n 0.9438750 24302.0n 0.9438750
+ 24302.1n 0.9437500 24402.0n 0.9437500 24402.1n 0.9436250 24502.0n 0.9436250 24502.1n 0.9435000
+ 24602.0n 0.9435000 24602.1n 0.9433750 24702.0n 0.9433750 24702.1n 0.9432500 24802.0n 0.9432500
+ 24802.1n 0.9431250 24902.0n 0.9431250 24902.1n 0.9430000 25000.0n 0.9430000)
Vsn sn 0 pwl( 0.0n 0.9489500 102.0n 0.9489500 102.1n 0.9490500 202.0n 0.9490500 202.1n 0.9489000 302.0n 0.9489000
+ 302.1n 0.9491000 402.0n 0.9491000 402.1n 0.9487500 502.0n 0.9487500 502.1n 0.9492500
+ 602.0n 0.9492500 602.1n 0.9485000 702.0n 0.9485000 702.1n 0.9495000 802.0n 0.9495000
+ 802.1n 0.9480000 902.0n 0.9480000 902.1n 0.9500000 1002.0n 0.9500000 1002.1n 0.9465000
+ 1102.0n 0.9465000 1102.1n 0.9515000 1202.0n 0.9515000 1202.1n 0.9440000 1302.0n 0.9440000
+ 1302.1n 0.9540000 1402.0n 0.9540000 1402.1n 0.9390000 1502.0n 0.9390000 1502.1n 0.9590000
+ 1602.0n 0.9590000 1602.1n 0.9240000 1702.0n 0.9240000 1702.1n 0.9740000 1802.0n 0.9740000
+ 1802.1n 0.8990000 1902.0n 0.8990000 1902.1n 0.9990000 2002.0n 0.9990000 2002.1n 0.5975000
+ 2102.0n 0.5975000 2102.1n 0.6025000 2202.0n 0.6025000 2202.1n 0.5995000 2302.0n 0.5995000
+ 2302.1n 0.6005000 2402.0n 0.6005000 2402.1n 0.6975000 2502.0n 0.6975000 2502.1n 0.7025000
+ 2602.0n 0.7025000 2602.1n 0.6995000 2702.0n 0.6995000 2702.1n 0.7005000 2802.0n 0.7005000
+ 2802.1n 0.7975000 2902.0n 0.7975000 2902.1n 0.8025000 3002.0n 0.8025000 3002.1n 0.7995000
+ 3102.0n 0.7995000 3102.1n 0.8005000 3202.0n 0.8005000 3202.1n 0.8975000 3302.0n 0.8975000
+ 3302.1n 0.9025000 3402.0n 0.9025000 3402.1n 0.8995000 3502.0n 0.8995000 3502.1n 0.9005000
+ 3602.0n 0.9005000 3602.1n 0.9465000 3702.0n 0.9465000 3702.1n 0.9515000 3802.0n 0.9515000
+ 3802.1n 0.9485000 3902.0n 0.9485000 3902.1n 0.9495000 4002.0n 0.9495000 4002.1n 0.9975000
+ 4102.0n 0.9975000 4102.1n 1.0025000 4202.0n 1.0025000 4202.1n 0.9995000 4302.0n 0.9995000
+ 4302.1n 1.0005000 4402.0n 1.0005000 4402.1n 1.0975000 4502.0n 1.0975000 4502.1n 1.1025000
+ 4602.0n 1.1025000 4602.1n 1.0995000 4702.0n 1.0995000 4702.1n 1.1005000 4802.0n 1.1005000
+ 4802.1n 1.1975000 4902.0n 1.1975000 4902.1n 1.2025000 5002.0n 1.2025000 5002.1n 1.1995000
+ 5102.0n 1.1995000 5102.1n 1.2005000 5202.0n 1.2005000 5202.1n 1.2975000 5302.0n 1.2975000
+ 5302.1n 1.3025000 5402.0n 1.3025000 5402.1n 1.2995000 5502.0n 1.2995000 5502.1n 1.3005000
+ 5602.0n 1.3005000 5602.1n 0.9550000 5702.0n 0.9550000 5702.1n 0.9548750 5802.0n 0.9548750
+ 5802.1n 0.9547500 5902.0n 0.9547500 5902.1n 0.9546250 6002.0n 0.9546250 6002.1n 0.9545000
+ 6102.0n 0.9545000 6102.1n 0.9543750 6202.0n 0.9543750 6202.1n 0.9542500 6302.0n 0.9542500
+ 6302.1n 0.9541250 6402.0n 0.9541250 6402.1n 0.9540000 6502.0n 0.9540000 6502.1n 0.9538750
+ 6602.0n 0.9538750 6602.1n 0.9537500 6702.0n 0.9537500 6702.1n 0.9536250 6802.0n 0.9536250
+ 6802.1n 0.9535000 6902.0n 0.9535000 6902.1n 0.9533750 7002.0n 0.9533750 7002.1n 0.9532500
+ 7102.0n 0.9532500 7102.1n 0.9531250 7202.0n 0.9531250 7202.1n 0.9530000 7302.0n 0.9530000
+ 7302.1n 0.9528750 7402.0n 0.9528750 7402.1n 0.9527500 7502.0n 0.9527500 7502.1n 0.9526250
+ 7602.0n 0.9526250 7602.1n 0.9525000 7702.0n 0.9525000 7702.1n 0.9523750 7802.0n 0.9523750
+ 7802.1n 0.9522500 7902.0n 0.9522500 7902.1n 0.9521250 8002.0n 0.9521250 8002.1n 0.9520000
+ 8102.0n 0.9520000 8102.1n 0.9518750 8202.0n 0.9518750 8202.1n 0.9517500 8302.0n 0.9517500
+ 8302.1n 0.9516250 8402.0n 0.9516250 8402.1n 0.9515000 8502.0n 0.9515000 8502.1n 0.9513750
+ 8602.0n 0.9513750 8602.1n 0.9512500 8702.0n 0.9512500 8702.1n 0.9511250 8802.0n 0.9511250
+ 8802.1n 0.9510000 8902.0n 0.9510000 8902.1n 0.9508750 9002.0n 0.9508750 9002.1n 0.9507500
+ 9102.0n 0.9507500 9102.1n 0.9506250 9202.0n 0.9506250 9202.1n 0.9505000 9302.0n 0.9505000
+ 9302.1n 0.9503750 9402.0n 0.9503750 9402.1n 0.9502500 9502.0n 0.9502500 9502.1n 0.9501250
+ 9602.0n 0.9501250 9602.1n 0.9500000 9702.0n 0.9500000 9702.1n 0.9498750 9802.0n 0.9498750
+ 9802.1n 0.9497500 9902.0n 0.9497500 9902.1n 0.9496250 10002.0n 0.9496250 10002.1n 0.9495000
+ 10102.0n 0.9495000 10102.1n 0.9493750 10202.0n 0.9493750 10202.1n 0.9492500 10302.0n 0.9492500
+ 10302.1n 0.9491250 10402.0n 0.9491250 10402.1n 0.9490000 10502.0n 0.9490000 10502.1n 0.9488750
+ 10602.0n 0.9488750 10602.1n 0.9487500 10702.0n 0.9487500 10702.1n 0.9486250 10802.0n 0.9486250
+ 10802.1n 0.9485000 10902.0n 0.9485000 10902.1n 0.9483750 11002.0n 0.9483750 11002.1n 0.9482500
+ 11102.0n 0.9482500 11102.1n 0.9481250 11202.0n 0.9481250 11202.1n 0.9480000 11302.0n 0.9480000
+ 11302.1n 0.9478750 11402.0n 0.9478750 11402.1n 0.9477500 11502.0n 0.9477500 11502.1n 0.9476250
+ 11602.0n 0.9476250 11602.1n 0.9475000 11702.0n 0.9475000 11702.1n 0.9473750 11802.0n 0.9473750
+ 11802.1n 0.9472500 11902.0n 0.9472500 11902.1n 0.9471250 12002.0n 0.9471250 12002.1n 0.9470000
+ 12102.0n 0.9470000 12102.1n 0.9468750 12202.0n 0.9468750 12202.1n 0.9467500 12302.0n 0.9467500
+ 12302.1n 0.9466250 12402.0n 0.9466250 12402.1n 0.9465000 12502.0n 0.9465000 12502.1n 0.9463750
+ 12602.0n 0.9463750 12602.1n 0.9462500 12702.0n 0.9462500 12702.1n 0.9461250 12802.0n 0.9461250
+ 12802.1n 0.9460000 12902.0n 0.9460000 12902.1n 0.9458750 13002.0n 0.9458750 13002.1n 0.9457500
+ 13102.0n 0.9457500 13102.1n 0.9456250 13202.0n 0.9456250 13202.1n 0.9455000 13302.0n 0.9455000
+ 13302.1n 0.9453750 13402.0n 0.9453750 13402.1n 0.9452500 13502.0n 0.9452500 13502.1n 0.9451250
+ 13602.0n 0.9451250 13602.1n 0.9450000 13702.0n 0.9450000 13702.1n 0.9448750 13802.0n 0.9448750
+ 13802.1n 0.9447500 13902.0n 0.9447500 13902.1n 0.9446250 14002.0n 0.9446250 14002.1n 0.9445000
+ 14102.0n 0.9445000 14102.1n 0.9443750 14202.0n 0.9443750 14202.1n 0.9442500 14302.0n 0.9442500
+ 14302.1n 0.9441250 14402.0n 0.9441250 14402.1n 0.9440000 14502.0n 0.9440000 14502.1n 0.9438750
+ 14602.0n 0.9438750 14602.1n 0.9437500 14702.0n 0.9437500 14702.1n 0.9436250 14802.0n 0.9436250
+ 14802.1n 0.9435000 14902.0n 0.9435000 14902.1n 0.9433750 15002.0n 0.9433750 15002.1n 0.9432500
+ 15102.0n 0.9432500 15102.1n 0.9431250 15202.0n 0.9431250 15202.1n 0.9430000 15302.0n 0.9430000
+ 15302.1n 0.9430000 15402.0n 0.9430000 15402.1n 0.9431250 15502.0n 0.9431250 15502.1n 0.9432500
+ 15602.0n 0.9432500 15602.1n 0.9433750 15702.0n 0.9433750 15702.1n 0.9435000 15802.0n 0.9435000
+ 15802.1n 0.9436250 15902.0n 0.9436250 15902.1n 0.9437500 16002.0n 0.9437500 16002.1n 0.9438750
+ 16102.0n 0.9438750 16102.1n 0.9440000 16202.0n 0.9440000 16202.1n 0.9441250 16302.0n 0.9441250
+ 16302.1n 0.9442500 16402.0n 0.9442500 16402.1n 0.9443750 16502.0n 0.9443750 16502.1n 0.9445000
+ 16602.0n 0.9445000 16602.1n 0.9446250 16702.0n 0.9446250 16702.1n 0.9447500 16802.0n 0.9447500
+ 16802.1n 0.9448750 16902.0n 0.9448750 16902.1n 0.9450000 17002.0n 0.9450000 17002.1n 0.9451250
+ 17102.0n 0.9451250 17102.1n 0.9452500 17202.0n 0.9452500 17202.1n 0.9453750 17302.0n 0.9453750
+ 17302.1n 0.9455000 17402.0n 0.9455000 17402.1n 0.9456250 17502.0n 0.9456250 17502.1n 0.9457500
+ 17602.0n 0.9457500 17602.1n 0.9458750 17702.0n 0.9458750 17702.1n 0.9460000 17802.0n 0.9460000
+ 17802.1n 0.9461250 17902.0n 0.9461250 17902.1n 0.9462500 18002.0n 0.9462500 18002.1n 0.9463750
+ 18102.0n 0.9463750 18102.1n 0.9465000 18202.0n 0.9465000 18202.1n 0.9466250 18302.0n 0.9466250
+ 18302.1n 0.9467500 18402.0n 0.9467500 18402.1n 0.9468750 18502.0n 0.9468750 18502.1n 0.9470000
+ 18602.0n 0.9470000 18602.1n 0.9471250 18702.0n 0.9471250 18702.1n 0.9472500 18802.0n 0.9472500
+ 18802.1n 0.9473750 18902.0n 0.9473750 18902.1n 0.9475000 19002.0n 0.9475000 19002.1n 0.9476250
+ 19102.0n 0.9476250 19102.1n 0.9477500 19202.0n 0.9477500 19202.1n 0.9478750 19302.0n 0.9478750
+ 19302.1n 0.9480000 19402.0n 0.9480000 19402.1n 0.9481250 19502.0n 0.9481250 19502.1n 0.9482500
+ 19602.0n 0.9482500 19602.1n 0.9483750 19702.0n 0.9483750 19702.1n 0.9485000 19802.0n 0.9485000
+ 19802.1n 0.9486250 19902.0n 0.9486250 19902.1n 0.9487500 20002.0n 0.9487500 20002.1n 0.9488750
+ 20102.0n 0.9488750 20102.1n 0.9490000 20202.0n 0.9490000 20202.1n 0.9491250 20302.0n 0.9491250
+ 20302.1n 0.9492500 20402.0n 0.9492500 20402.1n 0.9493750 20502.0n 0.9493750 20502.1n 0.9495000
+ 20602.0n 0.9495000 20602.1n 0.9496250 20702.0n 0.9496250 20702.1n 0.9497500 20802.0n 0.9497500
+ 20802.1n 0.9498750 20902.0n 0.9498750 20902.1n 0.9500000 21002.0n 0.9500000 21002.1n 0.9501250
+ 21102.0n 0.9501250 21102.1n 0.9502500 21202.0n 0.9502500 21202.1n 0.9503750 21302.0n 0.9503750
+ 21302.1n 0.9505000 21402.0n 0.9505000 21402.1n 0.9506250 21502.0n 0.9506250 21502.1n 0.9507500
+ 21602.0n 0.9507500 21602.1n 0.9508750 21702.0n 0.9508750 21702.1n 0.9510000 21802.0n 0.9510000
+ 21802.1n 0.9511250 21902.0n 0.9511250 21902.1n 0.9512500 22002.0n 0.9512500 22002.1n 0.9513750
+ 22102.0n 0.9513750 22102.1n 0.9515000 22202.0n 0.9515000 22202.1n 0.9516250 22302.0n 0.9516250
+ 22302.1n 0.9517500 22402.0n 0.9517500 22402.1n 0.9518750 22502.0n 0.9518750 22502.1n 0.9520000
+ 22602.0n 0.9520000 22602.1n 0.9521250 22702.0n 0.9521250 22702.1n 0.9522500 22802.0n 0.9522500
+ 22802.1n 0.9523750 22902.0n 0.9523750 22902.1n 0.9525000 23002.0n 0.9525000 23002.1n 0.9526250
+ 23102.0n 0.9526250 23102.1n 0.9527500 23202.0n 0.9527500 23202.1n 0.9528750 23302.0n 0.9528750
+ 23302.1n 0.9530000 23402.0n 0.9530000 23402.1n 0.9531250 23502.0n 0.9531250 23502.1n 0.9532500
+ 23602.0n 0.9532500 23602.1n 0.9533750 23702.0n 0.9533750 23702.1n 0.9535000 23802.0n 0.9535000
+ 23802.1n 0.9536250 23902.0n 0.9536250 23902.1n 0.9537500 24002.0n 0.9537500 24002.1n 0.9538750
+ 24102.0n 0.9538750 24102.1n 0.9540000 24202.0n 0.9540000 24202.1n 0.9541250 24302.0n 0.9541250
+ 24302.1n 0.9542500 24402.0n 0.9542500 24402.1n 0.9543750 24502.0n 0.9543750 24502.1n 0.9545000
+ 24602.0n 0.9545000 24602.1n 0.9546250 24702.0n 0.9546250 24702.1n 0.9547500 24802.0n 0.9547500
+ 24802.1n 0.9548750 24902.0n 0.9548750 24902.1n 0.9550000 25000.0n 0.9550000)
Rsp sp inp {rsrc}
Rsn sn inn {rsrc}
Cinp inp 0 {cin}
Cinn inn 0 {cin}
Xc VDD 0 inp inn phi1 phi2 outp outn comparator
Cop outp 0 {cout}
Con outn 0 {cout}

* SR latch on the (return-to-zero) outputs: vlat = decision, held while Q and Qb are both 0
.subckt cmp_nor2 a b y VDD GND
XP1 n1 a VDD VDD sky130_fd_pr__pfet_01v8 L=0.15 W=2
XP2 y b n1 VDD sky130_fd_pr__pfet_01v8 L=0.15 W=2
XN1 y a GND GND sky130_fd_pr__nfet_01v8 L=0.15 W=1
XN2 y b GND GND sky130_fd_pr__nfet_01v8 L=0.15 W=1
.ends cmp_nor2
Xs1 outn vlatb vlat VDD 0 cmp_nor2
Xs2 outp vlat vlatb VDD 0 cmp_nor2
.nodeset v(vlat)=0 v(vlatb)=1.8

.lib /foss/pdks/sky130A/libs.tech/combined/sky130.lib.spice tt
.temp 27
.options reltol=1e-5
.save all
.save i(vdd)

.control
  set wr_singlescale
  tran 0.1n 25000n
  let vsp_ = v(sp)
  let vsn_ = v(sn)
  let vinp = v(inp)
  let vinn = v(inn)
  let voutp = v(outp)
  let voutn = v(outn)
  let idd = -i(Vdd)
  let vp1 = v(phi1)
  let vp2 = v(phi2)
  let vl = v(vlat)
  let vlb = v(vlatb)
  let vna = v(xc.a)
  let vnb = v(xc.b)
  let vtl = v(xc.tail)
  wrdata tran_g.csv vsp_ vsn_ vinp vinn voutp voutn idd vp1 vp2 vl vlb vna vnb vtl
.endc

.end
