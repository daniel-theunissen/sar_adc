** V-to-I converter bench (dc / op / transient), generated by make_bench_vi.py
.lib /foss/pdks/sky130A/libs.tech/combined/sky130.lib.spice tt
.temp 27
.include vi_converter.spice
.options reltol=1e-6

VDD VDD 0 1.8
* the regulated nodes i1 / i2 of the summing stage are held at V_ref2; the two zero-volt sources are ideal ammeters
Vref2 vref2 0 1.55
Vo1 vref2 iop 0
Vo2 vref2 ion 0
* inputs: V+ = Vcm + vd/2, V- = Vcm - vd/2.  vd = Vdc (swept in the dc runs) + sine or steps in the transient runs (selected by Vmode)
Vcm vcm 0 dc 0.5
Vdc vdc 0 dc 0
Vmode mode 0 dc 0
Vst vst 0 dc 0 pwl(0n 0.0000 200n 0.0000 200.1n 0.4000 1000n 0.4000 1000.1n -0.4000 1800n -0.4000 1800.1n 0.0000 2600n 0.0000)
Bd vd 0 V = v(vdc) + (1 - v(mode)) * 0.47203 * sin(2 * 3.14159265358979 * 113281.2 * time) + v(mode) * v(vst)
Bp inp 0 V = v(vcm) + 0.5 * v(vd)
Bn inn 0 V = v(vcm) - 0.5 * v(vd)
Vtst tst 0 dc 0 ac 0
xc VDD 0 inp inn iop ion tst vi_converter  lbrk=1p cbrk=1f
.nodeset v(xc.s1)=0.5 v(xc.s2)=0.5 v(xc.g1)=1.15 v(xc.g2)=1.15 v(xc.vsk)=0.65 v(xc.vbo)=0.9 v(xc.xa1.net1)=0.7 v(xc.xa2.net1)=0.7

.control
  set wr_singlescale
  set wr_vecnames
  * 1. operating points: mid scale, and the two ends of the input range (T1 or T2 nearly off)
  alter Vdc dc = 0
  op
  let idd = -i(VDD)
  let io1 = i(Vo1)
  let io2 = i(Vo2)
  print idd io1 io2 v(inp) v(inn) v(xc.s1) v(xc.s2) v(xc.g1) v(xc.g2) v(xc.vsk) v(xc.vbo) v(xc.xa1.net1) v(xc.xa2.net1) v(xc.xa1.vx) v(xc.xa2.vx) > op_mid.log
  print @m.xc.xt1.msky130_fd_pr__nfet_01v8[vds] @m.xc.xt1.msky130_fd_pr__nfet_01v8[vdsat] @m.xc.xt1.msky130_fd_pr__nfet_01v8[gm] @m.xc.xt1.msky130_fd_pr__nfet_01v8[id] >> op_mid.log
  print @m.xc.xt2.msky130_fd_pr__nfet_01v8[vds] @m.xc.xt2.msky130_fd_pr__nfet_01v8[vdsat] @m.xc.xt2.msky130_fd_pr__nfet_01v8[gm] @m.xc.xt2.msky130_fd_pr__nfet_01v8[id] >> op_mid.log
  print @m.xc.xs1.msky130_fd_pr__nfet_01v8[vds] @m.xc.xs1.msky130_fd_pr__nfet_01v8[vdsat] @m.xc.xs1.msky130_fd_pr__nfet_01v8[gm] @m.xc.xs1.msky130_fd_pr__nfet_01v8[id] >> op_mid.log
  print @m.xc.xs2.msky130_fd_pr__nfet_01v8[vds] @m.xc.xs2.msky130_fd_pr__nfet_01v8[vdsat] @m.xc.xs2.msky130_fd_pr__nfet_01v8[gm] @m.xc.xs2.msky130_fd_pr__nfet_01v8[id] >> op_mid.log
  print @m.xc.xmsk.msky130_fd_pr__nfet_01v8[vds] @m.xc.xmsk.msky130_fd_pr__nfet_01v8[vdsat] @m.xc.xmsk.msky130_fd_pr__nfet_01v8[gm] @m.xc.xmsk.msky130_fd_pr__nfet_01v8[id] >> op_mid.log
  print @m.xc.xmbo.msky130_fd_pr__pfet_01v8[vds] @m.xc.xmbo.msky130_fd_pr__pfet_01v8[vdsat] @m.xc.xmbo.msky130_fd_pr__pfet_01v8[gm] @m.xc.xmbo.msky130_fd_pr__pfet_01v8[id] >> op_mid.log
  print @m.xc.xa1.xm1.msky130_fd_pr__pfet_01v8[vds] @m.xc.xa1.xm1.msky130_fd_pr__pfet_01v8[vdsat] @m.xc.xa1.xm1.msky130_fd_pr__pfet_01v8[gm] @m.xc.xa1.xm1.msky130_fd_pr__pfet_01v8[id] >> op_mid.log
  print @m.xc.xa1.xm2.msky130_fd_pr__pfet_01v8[vds] @m.xc.xa1.xm2.msky130_fd_pr__pfet_01v8[vdsat] @m.xc.xa1.xm2.msky130_fd_pr__pfet_01v8[gm] @m.xc.xa1.xm2.msky130_fd_pr__pfet_01v8[id] >> op_mid.log
  print @m.xc.xa1.xm3.msky130_fd_pr__nfet_01v8[vds] @m.xc.xa1.xm3.msky130_fd_pr__nfet_01v8[vdsat] @m.xc.xa1.xm3.msky130_fd_pr__nfet_01v8[gm] @m.xc.xa1.xm3.msky130_fd_pr__nfet_01v8[id] >> op_mid.log
  print @m.xc.xa1.xm4.msky130_fd_pr__nfet_01v8[vds] @m.xc.xa1.xm4.msky130_fd_pr__nfet_01v8[vdsat] @m.xc.xa1.xm4.msky130_fd_pr__nfet_01v8[gm] @m.xc.xa1.xm4.msky130_fd_pr__nfet_01v8[id] >> op_mid.log
  print @m.xc.xa1.xm5.msky130_fd_pr__pfet_01v8[vds] @m.xc.xa1.xm5.msky130_fd_pr__pfet_01v8[vdsat] @m.xc.xa1.xm5.msky130_fd_pr__pfet_01v8[gm] @m.xc.xa1.xm5.msky130_fd_pr__pfet_01v8[id] >> op_mid.log
  print @m.xc.xa2.xm1.msky130_fd_pr__pfet_01v8[vds] @m.xc.xa2.xm1.msky130_fd_pr__pfet_01v8[vdsat] @m.xc.xa2.xm1.msky130_fd_pr__pfet_01v8[gm] @m.xc.xa2.xm1.msky130_fd_pr__pfet_01v8[id] >> op_mid.log
  print @m.xc.xa2.xm2.msky130_fd_pr__pfet_01v8[vds] @m.xc.xa2.xm2.msky130_fd_pr__pfet_01v8[vdsat] @m.xc.xa2.xm2.msky130_fd_pr__pfet_01v8[gm] @m.xc.xa2.xm2.msky130_fd_pr__pfet_01v8[id] >> op_mid.log
  print @m.xc.xa2.xm3.msky130_fd_pr__nfet_01v8[vds] @m.xc.xa2.xm3.msky130_fd_pr__nfet_01v8[vdsat] @m.xc.xa2.xm3.msky130_fd_pr__nfet_01v8[gm] @m.xc.xa2.xm3.msky130_fd_pr__nfet_01v8[id] >> op_mid.log
  print @m.xc.xa2.xm4.msky130_fd_pr__nfet_01v8[vds] @m.xc.xa2.xm4.msky130_fd_pr__nfet_01v8[vdsat] @m.xc.xa2.xm4.msky130_fd_pr__nfet_01v8[gm] @m.xc.xa2.xm4.msky130_fd_pr__nfet_01v8[id] >> op_mid.log
  print @m.xc.xa2.xm5.msky130_fd_pr__pfet_01v8[vds] @m.xc.xa2.xm5.msky130_fd_pr__pfet_01v8[vdsat] @m.xc.xa2.xm5.msky130_fd_pr__pfet_01v8[gm] @m.xc.xa2.xm5.msky130_fd_pr__pfet_01v8[id] >> op_mid.log
  alter Vdc dc = -0.49
  op
  let idd = -i(VDD)
  let io1 = i(Vo1)
  let io2 = i(Vo2)
  print idd io1 io2 v(inp) v(inn) v(xc.s1) v(xc.s2) v(xc.g1) v(xc.g2) v(xc.vsk) v(xc.vbo) v(xc.xa1.net1) v(xc.xa2.net1) v(xc.xa1.vx) v(xc.xa2.vx) > op_lo.log
  print @m.xc.xt1.msky130_fd_pr__nfet_01v8[vds] @m.xc.xt1.msky130_fd_pr__nfet_01v8[vdsat] @m.xc.xt1.msky130_fd_pr__nfet_01v8[gm] @m.xc.xt1.msky130_fd_pr__nfet_01v8[id] >> op_lo.log
  print @m.xc.xt2.msky130_fd_pr__nfet_01v8[vds] @m.xc.xt2.msky130_fd_pr__nfet_01v8[vdsat] @m.xc.xt2.msky130_fd_pr__nfet_01v8[gm] @m.xc.xt2.msky130_fd_pr__nfet_01v8[id] >> op_lo.log
  print @m.xc.xs1.msky130_fd_pr__nfet_01v8[vds] @m.xc.xs1.msky130_fd_pr__nfet_01v8[vdsat] @m.xc.xs1.msky130_fd_pr__nfet_01v8[gm] @m.xc.xs1.msky130_fd_pr__nfet_01v8[id] >> op_lo.log
  print @m.xc.xs2.msky130_fd_pr__nfet_01v8[vds] @m.xc.xs2.msky130_fd_pr__nfet_01v8[vdsat] @m.xc.xs2.msky130_fd_pr__nfet_01v8[gm] @m.xc.xs2.msky130_fd_pr__nfet_01v8[id] >> op_lo.log
  print @m.xc.xmsk.msky130_fd_pr__nfet_01v8[vds] @m.xc.xmsk.msky130_fd_pr__nfet_01v8[vdsat] @m.xc.xmsk.msky130_fd_pr__nfet_01v8[gm] @m.xc.xmsk.msky130_fd_pr__nfet_01v8[id] >> op_lo.log
  print @m.xc.xmbo.msky130_fd_pr__pfet_01v8[vds] @m.xc.xmbo.msky130_fd_pr__pfet_01v8[vdsat] @m.xc.xmbo.msky130_fd_pr__pfet_01v8[gm] @m.xc.xmbo.msky130_fd_pr__pfet_01v8[id] >> op_lo.log
  print @m.xc.xa1.xm1.msky130_fd_pr__pfet_01v8[vds] @m.xc.xa1.xm1.msky130_fd_pr__pfet_01v8[vdsat] @m.xc.xa1.xm1.msky130_fd_pr__pfet_01v8[gm] @m.xc.xa1.xm1.msky130_fd_pr__pfet_01v8[id] >> op_lo.log
  print @m.xc.xa1.xm2.msky130_fd_pr__pfet_01v8[vds] @m.xc.xa1.xm2.msky130_fd_pr__pfet_01v8[vdsat] @m.xc.xa1.xm2.msky130_fd_pr__pfet_01v8[gm] @m.xc.xa1.xm2.msky130_fd_pr__pfet_01v8[id] >> op_lo.log
  print @m.xc.xa1.xm3.msky130_fd_pr__nfet_01v8[vds] @m.xc.xa1.xm3.msky130_fd_pr__nfet_01v8[vdsat] @m.xc.xa1.xm3.msky130_fd_pr__nfet_01v8[gm] @m.xc.xa1.xm3.msky130_fd_pr__nfet_01v8[id] >> op_lo.log
  print @m.xc.xa1.xm4.msky130_fd_pr__nfet_01v8[vds] @m.xc.xa1.xm4.msky130_fd_pr__nfet_01v8[vdsat] @m.xc.xa1.xm4.msky130_fd_pr__nfet_01v8[gm] @m.xc.xa1.xm4.msky130_fd_pr__nfet_01v8[id] >> op_lo.log
  print @m.xc.xa1.xm5.msky130_fd_pr__pfet_01v8[vds] @m.xc.xa1.xm5.msky130_fd_pr__pfet_01v8[vdsat] @m.xc.xa1.xm5.msky130_fd_pr__pfet_01v8[gm] @m.xc.xa1.xm5.msky130_fd_pr__pfet_01v8[id] >> op_lo.log
  print @m.xc.xa2.xm1.msky130_fd_pr__pfet_01v8[vds] @m.xc.xa2.xm1.msky130_fd_pr__pfet_01v8[vdsat] @m.xc.xa2.xm1.msky130_fd_pr__pfet_01v8[gm] @m.xc.xa2.xm1.msky130_fd_pr__pfet_01v8[id] >> op_lo.log
  print @m.xc.xa2.xm2.msky130_fd_pr__pfet_01v8[vds] @m.xc.xa2.xm2.msky130_fd_pr__pfet_01v8[vdsat] @m.xc.xa2.xm2.msky130_fd_pr__pfet_01v8[gm] @m.xc.xa2.xm2.msky130_fd_pr__pfet_01v8[id] >> op_lo.log
  print @m.xc.xa2.xm3.msky130_fd_pr__nfet_01v8[vds] @m.xc.xa2.xm3.msky130_fd_pr__nfet_01v8[vdsat] @m.xc.xa2.xm3.msky130_fd_pr__nfet_01v8[gm] @m.xc.xa2.xm3.msky130_fd_pr__nfet_01v8[id] >> op_lo.log
  print @m.xc.xa2.xm4.msky130_fd_pr__nfet_01v8[vds] @m.xc.xa2.xm4.msky130_fd_pr__nfet_01v8[vdsat] @m.xc.xa2.xm4.msky130_fd_pr__nfet_01v8[gm] @m.xc.xa2.xm4.msky130_fd_pr__nfet_01v8[id] >> op_lo.log
  print @m.xc.xa2.xm5.msky130_fd_pr__pfet_01v8[vds] @m.xc.xa2.xm5.msky130_fd_pr__pfet_01v8[vdsat] @m.xc.xa2.xm5.msky130_fd_pr__pfet_01v8[gm] @m.xc.xa2.xm5.msky130_fd_pr__pfet_01v8[id] >> op_lo.log
  alter Vdc dc = 0.49
  op
  let idd = -i(VDD)
  let io1 = i(Vo1)
  let io2 = i(Vo2)
  print idd io1 io2 v(inp) v(inn) v(xc.s1) v(xc.s2) v(xc.g1) v(xc.g2) v(xc.vsk) v(xc.vbo) v(xc.xa1.net1) v(xc.xa2.net1) v(xc.xa1.vx) v(xc.xa2.vx) > op_hi.log
  print @m.xc.xt1.msky130_fd_pr__nfet_01v8[vds] @m.xc.xt1.msky130_fd_pr__nfet_01v8[vdsat] @m.xc.xt1.msky130_fd_pr__nfet_01v8[gm] @m.xc.xt1.msky130_fd_pr__nfet_01v8[id] >> op_hi.log
  print @m.xc.xt2.msky130_fd_pr__nfet_01v8[vds] @m.xc.xt2.msky130_fd_pr__nfet_01v8[vdsat] @m.xc.xt2.msky130_fd_pr__nfet_01v8[gm] @m.xc.xt2.msky130_fd_pr__nfet_01v8[id] >> op_hi.log
  print @m.xc.xs1.msky130_fd_pr__nfet_01v8[vds] @m.xc.xs1.msky130_fd_pr__nfet_01v8[vdsat] @m.xc.xs1.msky130_fd_pr__nfet_01v8[gm] @m.xc.xs1.msky130_fd_pr__nfet_01v8[id] >> op_hi.log
  print @m.xc.xs2.msky130_fd_pr__nfet_01v8[vds] @m.xc.xs2.msky130_fd_pr__nfet_01v8[vdsat] @m.xc.xs2.msky130_fd_pr__nfet_01v8[gm] @m.xc.xs2.msky130_fd_pr__nfet_01v8[id] >> op_hi.log
  print @m.xc.xmsk.msky130_fd_pr__nfet_01v8[vds] @m.xc.xmsk.msky130_fd_pr__nfet_01v8[vdsat] @m.xc.xmsk.msky130_fd_pr__nfet_01v8[gm] @m.xc.xmsk.msky130_fd_pr__nfet_01v8[id] >> op_hi.log
  print @m.xc.xmbo.msky130_fd_pr__pfet_01v8[vds] @m.xc.xmbo.msky130_fd_pr__pfet_01v8[vdsat] @m.xc.xmbo.msky130_fd_pr__pfet_01v8[gm] @m.xc.xmbo.msky130_fd_pr__pfet_01v8[id] >> op_hi.log
  print @m.xc.xa1.xm1.msky130_fd_pr__pfet_01v8[vds] @m.xc.xa1.xm1.msky130_fd_pr__pfet_01v8[vdsat] @m.xc.xa1.xm1.msky130_fd_pr__pfet_01v8[gm] @m.xc.xa1.xm1.msky130_fd_pr__pfet_01v8[id] >> op_hi.log
  print @m.xc.xa1.xm2.msky130_fd_pr__pfet_01v8[vds] @m.xc.xa1.xm2.msky130_fd_pr__pfet_01v8[vdsat] @m.xc.xa1.xm2.msky130_fd_pr__pfet_01v8[gm] @m.xc.xa1.xm2.msky130_fd_pr__pfet_01v8[id] >> op_hi.log
  print @m.xc.xa1.xm3.msky130_fd_pr__nfet_01v8[vds] @m.xc.xa1.xm3.msky130_fd_pr__nfet_01v8[vdsat] @m.xc.xa1.xm3.msky130_fd_pr__nfet_01v8[gm] @m.xc.xa1.xm3.msky130_fd_pr__nfet_01v8[id] >> op_hi.log
  print @m.xc.xa1.xm4.msky130_fd_pr__nfet_01v8[vds] @m.xc.xa1.xm4.msky130_fd_pr__nfet_01v8[vdsat] @m.xc.xa1.xm4.msky130_fd_pr__nfet_01v8[gm] @m.xc.xa1.xm4.msky130_fd_pr__nfet_01v8[id] >> op_hi.log
  print @m.xc.xa1.xm5.msky130_fd_pr__pfet_01v8[vds] @m.xc.xa1.xm5.msky130_fd_pr__pfet_01v8[vdsat] @m.xc.xa1.xm5.msky130_fd_pr__pfet_01v8[gm] @m.xc.xa1.xm5.msky130_fd_pr__pfet_01v8[id] >> op_hi.log
  print @m.xc.xa2.xm1.msky130_fd_pr__pfet_01v8[vds] @m.xc.xa2.xm1.msky130_fd_pr__pfet_01v8[vdsat] @m.xc.xa2.xm1.msky130_fd_pr__pfet_01v8[gm] @m.xc.xa2.xm1.msky130_fd_pr__pfet_01v8[id] >> op_hi.log
  print @m.xc.xa2.xm2.msky130_fd_pr__pfet_01v8[vds] @m.xc.xa2.xm2.msky130_fd_pr__pfet_01v8[vdsat] @m.xc.xa2.xm2.msky130_fd_pr__pfet_01v8[gm] @m.xc.xa2.xm2.msky130_fd_pr__pfet_01v8[id] >> op_hi.log
  print @m.xc.xa2.xm3.msky130_fd_pr__nfet_01v8[vds] @m.xc.xa2.xm3.msky130_fd_pr__nfet_01v8[vdsat] @m.xc.xa2.xm3.msky130_fd_pr__nfet_01v8[gm] @m.xc.xa2.xm3.msky130_fd_pr__nfet_01v8[id] >> op_hi.log
  print @m.xc.xa2.xm4.msky130_fd_pr__nfet_01v8[vds] @m.xc.xa2.xm4.msky130_fd_pr__nfet_01v8[vdsat] @m.xc.xa2.xm4.msky130_fd_pr__nfet_01v8[gm] @m.xc.xa2.xm4.msky130_fd_pr__nfet_01v8[id] >> op_hi.log
  print @m.xc.xa2.xm5.msky130_fd_pr__pfet_01v8[vds] @m.xc.xa2.xm5.msky130_fd_pr__pfet_01v8[vdsat] @m.xc.xa2.xm5.msky130_fd_pr__pfet_01v8[gm] @m.xc.xa2.xm5.msky130_fd_pr__pfet_01v8[id] >> op_hi.log
  alter Vdc dc = 0

  * 2. static transfer: vd from -(half + 0.05) to +(half + 0.05)
  dc Vdc -0.550 0.550 0.002
  let io1 = i(Vo1)
  let io2 = i(Vo2)
  let vs1 = v(xc.s1)
  let vs2 = v(xc.s2)
  let vg1 = v(xc.g1)
  let vg2 = v(xc.g2)
  let vinp = v(inp)
  let vinn = v(inn)
  let idd = -i(VDD)
  wrdata dc_sweep.csv io1 io2 vs1 vs2 vg1 vg2 vinp vinn idd

  * 3. input common-mode sweeps at three differential inputs
  alter Vdc dc = -0.450
  dc Vcm 0.05 1.45 0.01
  let io1 = i(Vo1)
  let io2 = i(Vo2)
  let vs1 = v(xc.s1)
  let vs2 = v(xc.s2)
  let vg1 = v(xc.g1)
  let vg2 = v(xc.g2)
  let vinp = v(inp)
  let vinn = v(inn)
  let idd = -i(VDD)
  wrdata cm_sweep_lo.csv io1 io2 vs1 vs2 vg1 vg2 vinp vinn idd
  alter Vdc dc = 0
  dc Vcm 0.05 1.45 0.01
  let io1 = i(Vo1)
  let io2 = i(Vo2)
  let vs1 = v(xc.s1)
  let vs2 = v(xc.s2)
  let vg1 = v(xc.g1)
  let vg2 = v(xc.g2)
  let vinp = v(inp)
  let vinn = v(inn)
  let idd = -i(VDD)
  wrdata cm_sweep_mid.csv io1 io2 vs1 vs2 vg1 vg2 vinp vinn idd
  alter Vdc dc = 0.450
  dc Vcm 0.05 1.45 0.01
  let io1 = i(Vo1)
  let io2 = i(Vo2)
  let vs1 = v(xc.s1)
  let vs2 = v(xc.s2)
  let vg1 = v(xc.g1)
  let vg2 = v(xc.g2)
  let vinp = v(inp)
  let vinn = v(inn)
  let idd = -i(VDD)
  wrdata cm_sweep_hi.csv io1 io2 vs1 vs2 vg1 vg2 vinp vinn idd
  alter Vdc dc = 0

  * 4. voltage of the regulated nodes (where do T1 and T2 stay saturated?)
  dc Vref2 0.3 1.8 0.01
  let io1 = i(Vo1)
  let io2 = i(Vo2)
  let vs1 = v(xc.s1)
  let vs2 = v(xc.s2)
  let vg1 = v(xc.g1)
  let vg2 = v(xc.g2)
  let vinp = v(inp)
  let vinn = v(inn)
  let idd = -i(VDD)
  wrdata out_sweep.csv io1 io2 vs1 vs2 vg1 vg2 vinp vinn idd
  alter Vref2 dc = 1.55

  * 5. transient with the coherent sine (-0.5 dBFS, 113.28 kHz, 29 periods in 256 us)
  alter Vmode dc = 0
  option reltol=1e-4
  tran 5n 256.0u
  let vdiff = v(inp) - v(inn)
  let io1 = i(Vo1)
  let io2 = i(Vo2)
  wrdata tran_sine.csv vdiff io1 io2

  * 6. transient with large steps (settling): 0 -> +0.8 half -> -0.8 half -> 0
  alter Vmode dc = 1
  tran 0.1n 2.6u
  let vdiff = v(inp) - v(inn)
  let io1 = i(Vo1)
  let io2 = i(Vo2)
  let vg1 = v(xc.g1)
  let vs1 = v(xc.s1)
  wrdata tran_step.csv vdiff io1 io2 vg1 vs1
.endc
.end
