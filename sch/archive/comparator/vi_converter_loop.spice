** V-to-I converter bench (loop gain), generated by make_bench_vi.py
.lib /foss/pdks/sky130A/libs.tech/combined/sky130.lib.spice tt
.temp 27
.include vi_converter.spice
.options reltol=1e-6

VDD VDD 0 1.8
* the regulated nodes i1 / i2 of the summing stage are held at V_ref2; the two zero-volt sources are ideal ammeters
Vref2 vref2 0 1.55
Vo1 vref2 iop 0
Vo2 vref2 ion 0
* inputs: V+ = Vcm + vd/2, V- = Vcm - vd/2.  vd = Vdc (swept in the dc runs) + sine or steps in the transient runs (selected by Vmode)
Vcm vcm 0 dc 0.5
Vdc vdc 0 dc 0
Vmode mode 0 dc 0
Vst vst 0 dc 0 pwl(0n 0.0000 200n 0.0000 200.1n 0.4000 1000n 0.4000 1000.1n -0.4000 1800n -0.4000 1800.1n 0.0000 2600n 0.0000)
Bd vd 0 V = v(vdc) + (1 - v(mode)) * 0.47203 * sin(2 * 3.14159265358979 * 113281.2 * time) + v(mode) * v(vst)
Bp inp 0 V = v(vcm) + 0.5 * v(vd)
Bn inn 0 V = v(vcm) - 0.5 * v(vd)
Vtst tst 0 dc 0 ac 1
xc VDD 0 inp inn iop ion tst vi_converter  lbrk=1G cbrk=1G
.nodeset v(xc.s1)=0.5 v(xc.s2)=0.5 v(xc.g1)=1.15 v(xc.g2)=1.15 v(xc.vsk)=0.65 v(xc.vbo)=0.9 v(xc.xa1.net1)=0.7 v(xc.xa2.net1)=0.7

.control
  set wr_singlescale
  set wr_vecnames
  * loop gain of side 1: the feedback into OTA 1 is broken at fb1 (1 GH), the test signal comes in through 1 GF at `tst`.
  * T(s) = - v(s1) / v(fb1); v(fb1) is the test signal itself. Three operating points: mid scale and the two ends.
  alter Vdc dc = 0
  op
  ac dec 40 1k 10G
  let lg = -v(xc.s1)
  wrdata ac_loop_mid.csv lg
  alter Vdc dc = -0.450
  op
  ac dec 40 1k 10G
  let lg = -v(xc.s1)
  wrdata ac_loop_lo.csv lg
  alter Vdc dc = 0.450
  op
  ac dec 40 1k 10G
  let lg = -v(xc.s1)
  wrdata ac_loop_hi.csv lg
.endc
.end
