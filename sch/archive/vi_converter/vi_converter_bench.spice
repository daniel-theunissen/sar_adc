** V-to-I converter bench (dc / op / transient), generated by make_bench_vi.py
.lib /foss/pdks/sky130A/libs.tech/combined/sky130.lib.spice tt
.temp 27
.include vi_converter_fc.spice
.options reltol=1e-6

VDD VDD 0 1.8
* the regulated nodes i1 / i2 of the summing stage are held at V_ref2; the two zero-volt sources are ideal ammeters
Vref2 vref2 0 1.55
Vo1 vref2 iop 0
Vo2 vref2 ion 0
* inputs: V+ = Vcm + vd/2, V- = Vcm - vd/2.  vd = Vdc (swept in the dc runs) + sine or steps in the transient runs (selected by Vmode)
Vcm vcm 0 dc 0.45
Vdc vdc 0 dc 0
Vmode mode 0 dc 0
Vst vst 0 dc 0 pwl(0n 0.0000 200n 0.0000 200.1n 0.2160 1000n 0.2160 1000.1n -0.2160 1800n -0.2160 1800.1n 0.0000 2600n 0.0000)
Bd vd 0 V = v(vdc) + (1 - v(mode)) * 0.25490 * sin(2 * 3.14159265358979 * 113281.2 * time) + v(mode) * v(vst)
Bp inp 0 V = v(vcm) + 0.5 * v(vd)
Bn inn 0 V = v(vcm) - 0.5 * v(vd)
Vtst tst 0 dc 0 ac 1
* loop-break parts (the control block alters them to 1G / 1G for the .ac run)
Lb1 s1 fb1 1p
Cb1 tst fb1 1f
xc VDD 0 inp inn iop ion s1 fb1 vi_converter wt1=6.12 lt1=1 ws=13.13 ls=4 rsk=10 isk=0.999u rv=31518 cg=200f wpo=14.64 lpo=1 wto=17.69 lto=2 wso=12.02 lso=2 wco=4.62 lco=1 wpc=15.65 lpc=1 wmo=22.62 lmo=2 rbo=10 ibt=1u ibs=1.2u wgn=0.50 lgn=7.81 ibn=1.04u wgp=0.50 lgp=2.34 ibp=0.62u
.nodeset v(s1)=0.45 v(xc.s2)=0.45 v(xc.g1)=1.1 v(xc.g2)=1.1 v(xc.vsk)=0.65 v(xc.vbp1)=0.7 v(xc.vbn1)=0.65 v(xc.vbn2)=0.8 v(xc.vbp2)=0.45 v(xc.xa1.vx)=0.95 v(xc.xa1.fa)=0.25 v(xc.xa1.fb)=0.25 v(xc.xa1.d)=0.8 v(xc.xa1.m1)=1.6 v(xc.xa1.m2)=1.6 v(xc.xa2.vx)=0.95 v(xc.xa2.fa)=0.25 v(xc.xa2.fb)=0.25 v(xc.xa2.d)=0.8 v(xc.xa2.m1)=1.6 v(xc.xa2.m2)=1.6

.control
  set wr_singlescale
  set wr_vecnames
  * 1. operating points: mid scale, and the two ends of the input range (T1 or T2 nearly off)
  alter Vdc dc = 0
  op
  let idd = -i(VDD)
  let io1 = i(Vo1)
  let io2 = i(Vo2)
  print idd io1 io2 v(inp) v(inn) v(s1) v(xc.s2) v(xc.g1) v(xc.g2) v(xc.vsk) v(xc.vbp1) v(xc.vbn1) v(xc.vbn2) v(xc.vbp2) v(xc.xa1.vx) v(xc.xa2.vx) v(xc.xa1.fa) v(xc.xa1.fb) v(xc.xa1.d) v(xc.xa1.m1) v(xc.xa1.m2) v(xc.xa2.fa) v(xc.xa2.fb) v(xc.xa2.d) > op_mid.log
  print @m.xc.xt1.msky130_fd_pr__nfet_01v8[vds] @m.xc.xt1.msky130_fd_pr__nfet_01v8[vdsat] @m.xc.xt1.msky130_fd_pr__nfet_01v8[gm] @m.xc.xt1.msky130_fd_pr__nfet_01v8[id] >> op_mid.log
  print @m.xc.xt2.msky130_fd_pr__nfet_01v8[vds] @m.xc.xt2.msky130_fd_pr__nfet_01v8[vdsat] @m.xc.xt2.msky130_fd_pr__nfet_01v8[gm] @m.xc.xt2.msky130_fd_pr__nfet_01v8[id] >> op_mid.log
  print @m.xc.xs1.msky130_fd_pr__nfet_01v8[vds] @m.xc.xs1.msky130_fd_pr__nfet_01v8[vdsat] @m.xc.xs1.msky130_fd_pr__nfet_01v8[gm] @m.xc.xs1.msky130_fd_pr__nfet_01v8[id] >> op_mid.log
  print @m.xc.xs2.msky130_fd_pr__nfet_01v8[vds] @m.xc.xs2.msky130_fd_pr__nfet_01v8[vdsat] @m.xc.xs2.msky130_fd_pr__nfet_01v8[gm] @m.xc.xs2.msky130_fd_pr__nfet_01v8[id] >> op_mid.log
  print @m.xc.xmsk.msky130_fd_pr__nfet_01v8[vds] @m.xc.xmsk.msky130_fd_pr__nfet_01v8[vdsat] @m.xc.xmsk.msky130_fd_pr__nfet_01v8[gm] @m.xc.xmsk.msky130_fd_pr__nfet_01v8[id] >> op_mid.log
  print @m.xc.xa1.xm0.msky130_fd_pr__pfet_01v8[vds] @m.xc.xa1.xm0.msky130_fd_pr__pfet_01v8[vdsat] @m.xc.xa1.xm0.msky130_fd_pr__pfet_01v8[gm] @m.xc.xa1.xm0.msky130_fd_pr__pfet_01v8[id] >> op_mid.log
  print @m.xc.xa1.xm1.msky130_fd_pr__pfet_01v8_lvt[vds] @m.xc.xa1.xm1.msky130_fd_pr__pfet_01v8_lvt[vdsat] @m.xc.xa1.xm1.msky130_fd_pr__pfet_01v8_lvt[gm] @m.xc.xa1.xm1.msky130_fd_pr__pfet_01v8_lvt[id] >> op_mid.log
  print @m.xc.xa1.xm2.msky130_fd_pr__pfet_01v8_lvt[vds] @m.xc.xa1.xm2.msky130_fd_pr__pfet_01v8_lvt[vdsat] @m.xc.xa1.xm2.msky130_fd_pr__pfet_01v8_lvt[gm] @m.xc.xa1.xm2.msky130_fd_pr__pfet_01v8_lvt[id] >> op_mid.log
  print @m.xc.xa1.xm3.msky130_fd_pr__nfet_01v8[vds] @m.xc.xa1.xm3.msky130_fd_pr__nfet_01v8[vdsat] @m.xc.xa1.xm3.msky130_fd_pr__nfet_01v8[gm] @m.xc.xa1.xm3.msky130_fd_pr__nfet_01v8[id] >> op_mid.log
  print @m.xc.xa1.xm4.msky130_fd_pr__nfet_01v8[vds] @m.xc.xa1.xm4.msky130_fd_pr__nfet_01v8[vdsat] @m.xc.xa1.xm4.msky130_fd_pr__nfet_01v8[gm] @m.xc.xa1.xm4.msky130_fd_pr__nfet_01v8[id] >> op_mid.log
  print @m.xc.xa1.xm5.msky130_fd_pr__nfet_01v8[vds] @m.xc.xa1.xm5.msky130_fd_pr__nfet_01v8[vdsat] @m.xc.xa1.xm5.msky130_fd_pr__nfet_01v8[gm] @m.xc.xa1.xm5.msky130_fd_pr__nfet_01v8[id] >> op_mid.log
  print @m.xc.xa1.xm6.msky130_fd_pr__nfet_01v8[vds] @m.xc.xa1.xm6.msky130_fd_pr__nfet_01v8[vdsat] @m.xc.xa1.xm6.msky130_fd_pr__nfet_01v8[gm] @m.xc.xa1.xm6.msky130_fd_pr__nfet_01v8[id] >> op_mid.log
  print @m.xc.xa1.xm7.msky130_fd_pr__pfet_01v8[vds] @m.xc.xa1.xm7.msky130_fd_pr__pfet_01v8[vdsat] @m.xc.xa1.xm7.msky130_fd_pr__pfet_01v8[gm] @m.xc.xa1.xm7.msky130_fd_pr__pfet_01v8[id] >> op_mid.log
  print @m.xc.xa1.xm8.msky130_fd_pr__pfet_01v8[vds] @m.xc.xa1.xm8.msky130_fd_pr__pfet_01v8[vdsat] @m.xc.xa1.xm8.msky130_fd_pr__pfet_01v8[gm] @m.xc.xa1.xm8.msky130_fd_pr__pfet_01v8[id] >> op_mid.log
  print @m.xc.xa1.xm9.msky130_fd_pr__pfet_01v8[vds] @m.xc.xa1.xm9.msky130_fd_pr__pfet_01v8[vdsat] @m.xc.xa1.xm9.msky130_fd_pr__pfet_01v8[gm] @m.xc.xa1.xm9.msky130_fd_pr__pfet_01v8[id] >> op_mid.log
  print @m.xc.xa1.xm10.msky130_fd_pr__pfet_01v8[vds] @m.xc.xa1.xm10.msky130_fd_pr__pfet_01v8[vdsat] @m.xc.xa1.xm10.msky130_fd_pr__pfet_01v8[gm] @m.xc.xa1.xm10.msky130_fd_pr__pfet_01v8[id] >> op_mid.log
  print @m.xc.xa2.xm0.msky130_fd_pr__pfet_01v8[vds] @m.xc.xa2.xm0.msky130_fd_pr__pfet_01v8[vdsat] @m.xc.xa2.xm0.msky130_fd_pr__pfet_01v8[gm] @m.xc.xa2.xm0.msky130_fd_pr__pfet_01v8[id] >> op_mid.log
  print @m.xc.xa2.xm1.msky130_fd_pr__pfet_01v8_lvt[vds] @m.xc.xa2.xm1.msky130_fd_pr__pfet_01v8_lvt[vdsat] @m.xc.xa2.xm1.msky130_fd_pr__pfet_01v8_lvt[gm] @m.xc.xa2.xm1.msky130_fd_pr__pfet_01v8_lvt[id] >> op_mid.log
  print @m.xc.xa2.xm2.msky130_fd_pr__pfet_01v8_lvt[vds] @m.xc.xa2.xm2.msky130_fd_pr__pfet_01v8_lvt[vdsat] @m.xc.xa2.xm2.msky130_fd_pr__pfet_01v8_lvt[gm] @m.xc.xa2.xm2.msky130_fd_pr__pfet_01v8_lvt[id] >> op_mid.log
  print @m.xc.xa2.xm3.msky130_fd_pr__nfet_01v8[vds] @m.xc.xa2.xm3.msky130_fd_pr__nfet_01v8[vdsat] @m.xc.xa2.xm3.msky130_fd_pr__nfet_01v8[gm] @m.xc.xa2.xm3.msky130_fd_pr__nfet_01v8[id] >> op_mid.log
  print @m.xc.xa2.xm4.msky130_fd_pr__nfet_01v8[vds] @m.xc.xa2.xm4.msky130_fd_pr__nfet_01v8[vdsat] @m.xc.xa2.xm4.msky130_fd_pr__nfet_01v8[gm] @m.xc.xa2.xm4.msky130_fd_pr__nfet_01v8[id] >> op_mid.log
  print @m.xc.xa2.xm5.msky130_fd_pr__nfet_01v8[vds] @m.xc.xa2.xm5.msky130_fd_pr__nfet_01v8[vdsat] @m.xc.xa2.xm5.msky130_fd_pr__nfet_01v8[gm] @m.xc.xa2.xm5.msky130_fd_pr__nfet_01v8[id] >> op_mid.log
  print @m.xc.xa2.xm6.msky130_fd_pr__nfet_01v8[vds] @m.xc.xa2.xm6.msky130_fd_pr__nfet_01v8[vdsat] @m.xc.xa2.xm6.msky130_fd_pr__nfet_01v8[gm] @m.xc.xa2.xm6.msky130_fd_pr__nfet_01v8[id] >> op_mid.log
  print @m.xc.xa2.xm7.msky130_fd_pr__pfet_01v8[vds] @m.xc.xa2.xm7.msky130_fd_pr__pfet_01v8[vdsat] @m.xc.xa2.xm7.msky130_fd_pr__pfet_01v8[gm] @m.xc.xa2.xm7.msky130_fd_pr__pfet_01v8[id] >> op_mid.log
  print @m.xc.xa2.xm8.msky130_fd_pr__pfet_01v8[vds] @m.xc.xa2.xm8.msky130_fd_pr__pfet_01v8[vdsat] @m.xc.xa2.xm8.msky130_fd_pr__pfet_01v8[gm] @m.xc.xa2.xm8.msky130_fd_pr__pfet_01v8[id] >> op_mid.log
  print @m.xc.xa2.xm9.msky130_fd_pr__pfet_01v8[vds] @m.xc.xa2.xm9.msky130_fd_pr__pfet_01v8[vdsat] @m.xc.xa2.xm9.msky130_fd_pr__pfet_01v8[gm] @m.xc.xa2.xm9.msky130_fd_pr__pfet_01v8[id] >> op_mid.log
  print @m.xc.xa2.xm10.msky130_fd_pr__pfet_01v8[vds] @m.xc.xa2.xm10.msky130_fd_pr__pfet_01v8[vdsat] @m.xc.xa2.xm10.msky130_fd_pr__pfet_01v8[gm] @m.xc.xa2.xm10.msky130_fd_pr__pfet_01v8[id] >> op_mid.log
  alter Vdc dc = -0.2646
  op
  let idd = -i(VDD)
  let io1 = i(Vo1)
  let io2 = i(Vo2)
  print idd io1 io2 v(inp) v(inn) v(s1) v(xc.s2) v(xc.g1) v(xc.g2) v(xc.vsk) v(xc.vbp1) v(xc.vbn1) v(xc.vbn2) v(xc.vbp2) v(xc.xa1.vx) v(xc.xa2.vx) v(xc.xa1.fa) v(xc.xa1.fb) v(xc.xa1.d) v(xc.xa1.m1) v(xc.xa1.m2) v(xc.xa2.fa) v(xc.xa2.fb) v(xc.xa2.d) > op_lo.log
  print @m.xc.xt1.msky130_fd_pr__nfet_01v8[vds] @m.xc.xt1.msky130_fd_pr__nfet_01v8[vdsat] @m.xc.xt1.msky130_fd_pr__nfet_01v8[gm] @m.xc.xt1.msky130_fd_pr__nfet_01v8[id] >> op_lo.log
  print @m.xc.xt2.msky130_fd_pr__nfet_01v8[vds] @m.xc.xt2.msky130_fd_pr__nfet_01v8[vdsat] @m.xc.xt2.msky130_fd_pr__nfet_01v8[gm] @m.xc.xt2.msky130_fd_pr__nfet_01v8[id] >> op_lo.log
  print @m.xc.xs1.msky130_fd_pr__nfet_01v8[vds] @m.xc.xs1.msky130_fd_pr__nfet_01v8[vdsat] @m.xc.xs1.msky130_fd_pr__nfet_01v8[gm] @m.xc.xs1.msky130_fd_pr__nfet_01v8[id] >> op_lo.log
  print @m.xc.xs2.msky130_fd_pr__nfet_01v8[vds] @m.xc.xs2.msky130_fd_pr__nfet_01v8[vdsat] @m.xc.xs2.msky130_fd_pr__nfet_01v8[gm] @m.xc.xs2.msky130_fd_pr__nfet_01v8[id] >> op_lo.log
  print @m.xc.xmsk.msky130_fd_pr__nfet_01v8[vds] @m.xc.xmsk.msky130_fd_pr__nfet_01v8[vdsat] @m.xc.xmsk.msky130_fd_pr__nfet_01v8[gm] @m.xc.xmsk.msky130_fd_pr__nfet_01v8[id] >> op_lo.log
  print @m.xc.xa1.xm0.msky130_fd_pr__pfet_01v8[vds] @m.xc.xa1.xm0.msky130_fd_pr__pfet_01v8[vdsat] @m.xc.xa1.xm0.msky130_fd_pr__pfet_01v8[gm] @m.xc.xa1.xm0.msky130_fd_pr__pfet_01v8[id] >> op_lo.log
  print @m.xc.xa1.xm1.msky130_fd_pr__pfet_01v8_lvt[vds] @m.xc.xa1.xm1.msky130_fd_pr__pfet_01v8_lvt[vdsat] @m.xc.xa1.xm1.msky130_fd_pr__pfet_01v8_lvt[gm] @m.xc.xa1.xm1.msky130_fd_pr__pfet_01v8_lvt[id] >> op_lo.log
  print @m.xc.xa1.xm2.msky130_fd_pr__pfet_01v8_lvt[vds] @m.xc.xa1.xm2.msky130_fd_pr__pfet_01v8_lvt[vdsat] @m.xc.xa1.xm2.msky130_fd_pr__pfet_01v8_lvt[gm] @m.xc.xa1.xm2.msky130_fd_pr__pfet_01v8_lvt[id] >> op_lo.log
  print @m.xc.xa1.xm3.msky130_fd_pr__nfet_01v8[vds] @m.xc.xa1.xm3.msky130_fd_pr__nfet_01v8[vdsat] @m.xc.xa1.xm3.msky130_fd_pr__nfet_01v8[gm] @m.xc.xa1.xm3.msky130_fd_pr__nfet_01v8[id] >> op_lo.log
  print @m.xc.xa1.xm4.msky130_fd_pr__nfet_01v8[vds] @m.xc.xa1.xm4.msky130_fd_pr__nfet_01v8[vdsat] @m.xc.xa1.xm4.msky130_fd_pr__nfet_01v8[gm] @m.xc.xa1.xm4.msky130_fd_pr__nfet_01v8[id] >> op_lo.log
  print @m.xc.xa1.xm5.msky130_fd_pr__nfet_01v8[vds] @m.xc.xa1.xm5.msky130_fd_pr__nfet_01v8[vdsat] @m.xc.xa1.xm5.msky130_fd_pr__nfet_01v8[gm] @m.xc.xa1.xm5.msky130_fd_pr__nfet_01v8[id] >> op_lo.log
  print @m.xc.xa1.xm6.msky130_fd_pr__nfet_01v8[vds] @m.xc.xa1.xm6.msky130_fd_pr__nfet_01v8[vdsat] @m.xc.xa1.xm6.msky130_fd_pr__nfet_01v8[gm] @m.xc.xa1.xm6.msky130_fd_pr__nfet_01v8[id] >> op_lo.log
  print @m.xc.xa1.xm7.msky130_fd_pr__pfet_01v8[vds] @m.xc.xa1.xm7.msky130_fd_pr__pfet_01v8[vdsat] @m.xc.xa1.xm7.msky130_fd_pr__pfet_01v8[gm] @m.xc.xa1.xm7.msky130_fd_pr__pfet_01v8[id] >> op_lo.log
  print @m.xc.xa1.xm8.msky130_fd_pr__pfet_01v8[vds] @m.xc.xa1.xm8.msky130_fd_pr__pfet_01v8[vdsat] @m.xc.xa1.xm8.msky130_fd_pr__pfet_01v8[gm] @m.xc.xa1.xm8.msky130_fd_pr__pfet_01v8[id] >> op_lo.log
  print @m.xc.xa1.xm9.msky130_fd_pr__pfet_01v8[vds] @m.xc.xa1.xm9.msky130_fd_pr__pfet_01v8[vdsat] @m.xc.xa1.xm9.msky130_fd_pr__pfet_01v8[gm] @m.xc.xa1.xm9.msky130_fd_pr__pfet_01v8[id] >> op_lo.log
  print @m.xc.xa1.xm10.msky130_fd_pr__pfet_01v8[vds] @m.xc.xa1.xm10.msky130_fd_pr__pfet_01v8[vdsat] @m.xc.xa1.xm10.msky130_fd_pr__pfet_01v8[gm] @m.xc.xa1.xm10.msky130_fd_pr__pfet_01v8[id] >> op_lo.log
  print @m.xc.xa2.xm0.msky130_fd_pr__pfet_01v8[vds] @m.xc.xa2.xm0.msky130_fd_pr__pfet_01v8[vdsat] @m.xc.xa2.xm0.msky130_fd_pr__pfet_01v8[gm] @m.xc.xa2.xm0.msky130_fd_pr__pfet_01v8[id] >> op_lo.log
  print @m.xc.xa2.xm1.msky130_fd_pr__pfet_01v8_lvt[vds] @m.xc.xa2.xm1.msky130_fd_pr__pfet_01v8_lvt[vdsat] @m.xc.xa2.xm1.msky130_fd_pr__pfet_01v8_lvt[gm] @m.xc.xa2.xm1.msky130_fd_pr__pfet_01v8_lvt[id] >> op_lo.log
  print @m.xc.xa2.xm2.msky130_fd_pr__pfet_01v8_lvt[vds] @m.xc.xa2.xm2.msky130_fd_pr__pfet_01v8_lvt[vdsat] @m.xc.xa2.xm2.msky130_fd_pr__pfet_01v8_lvt[gm] @m.xc.xa2.xm2.msky130_fd_pr__pfet_01v8_lvt[id] >> op_lo.log
  print @m.xc.xa2.xm3.msky130_fd_pr__nfet_01v8[vds] @m.xc.xa2.xm3.msky130_fd_pr__nfet_01v8[vdsat] @m.xc.xa2.xm3.msky130_fd_pr__nfet_01v8[gm] @m.xc.xa2.xm3.msky130_fd_pr__nfet_01v8[id] >> op_lo.log
  print @m.xc.xa2.xm4.msky130_fd_pr__nfet_01v8[vds] @m.xc.xa2.xm4.msky130_fd_pr__nfet_01v8[vdsat] @m.xc.xa2.xm4.msky130_fd_pr__nfet_01v8[gm] @m.xc.xa2.xm4.msky130_fd_pr__nfet_01v8[id] >> op_lo.log
  print @m.xc.xa2.xm5.msky130_fd_pr__nfet_01v8[vds] @m.xc.xa2.xm5.msky130_fd_pr__nfet_01v8[vdsat] @m.xc.xa2.xm5.msky130_fd_pr__nfet_01v8[gm] @m.xc.xa2.xm5.msky130_fd_pr__nfet_01v8[id] >> op_lo.log
  print @m.xc.xa2.xm6.msky130_fd_pr__nfet_01v8[vds] @m.xc.xa2.xm6.msky130_fd_pr__nfet_01v8[vdsat] @m.xc.xa2.xm6.msky130_fd_pr__nfet_01v8[gm] @m.xc.xa2.xm6.msky130_fd_pr__nfet_01v8[id] >> op_lo.log
  print @m.xc.xa2.xm7.msky130_fd_pr__pfet_01v8[vds] @m.xc.xa2.xm7.msky130_fd_pr__pfet_01v8[vdsat] @m.xc.xa2.xm7.msky130_fd_pr__pfet_01v8[gm] @m.xc.xa2.xm7.msky130_fd_pr__pfet_01v8[id] >> op_lo.log
  print @m.xc.xa2.xm8.msky130_fd_pr__pfet_01v8[vds] @m.xc.xa2.xm8.msky130_fd_pr__pfet_01v8[vdsat] @m.xc.xa2.xm8.msky130_fd_pr__pfet_01v8[gm] @m.xc.xa2.xm8.msky130_fd_pr__pfet_01v8[id] >> op_lo.log
  print @m.xc.xa2.xm9.msky130_fd_pr__pfet_01v8[vds] @m.xc.xa2.xm9.msky130_fd_pr__pfet_01v8[vdsat] @m.xc.xa2.xm9.msky130_fd_pr__pfet_01v8[gm] @m.xc.xa2.xm9.msky130_fd_pr__pfet_01v8[id] >> op_lo.log
  print @m.xc.xa2.xm10.msky130_fd_pr__pfet_01v8[vds] @m.xc.xa2.xm10.msky130_fd_pr__pfet_01v8[vdsat] @m.xc.xa2.xm10.msky130_fd_pr__pfet_01v8[gm] @m.xc.xa2.xm10.msky130_fd_pr__pfet_01v8[id] >> op_lo.log
  alter Vdc dc = 0.2646
  op
  let idd = -i(VDD)
  let io1 = i(Vo1)
  let io2 = i(Vo2)
  print idd io1 io2 v(inp) v(inn) v(s1) v(xc.s2) v(xc.g1) v(xc.g2) v(xc.vsk) v(xc.vbp1) v(xc.vbn1) v(xc.vbn2) v(xc.vbp2) v(xc.xa1.vx) v(xc.xa2.vx) v(xc.xa1.fa) v(xc.xa1.fb) v(xc.xa1.d) v(xc.xa1.m1) v(xc.xa1.m2) v(xc.xa2.fa) v(xc.xa2.fb) v(xc.xa2.d) > op_hi.log
  print @m.xc.xt1.msky130_fd_pr__nfet_01v8[vds] @m.xc.xt1.msky130_fd_pr__nfet_01v8[vdsat] @m.xc.xt1.msky130_fd_pr__nfet_01v8[gm] @m.xc.xt1.msky130_fd_pr__nfet_01v8[id] >> op_hi.log
  print @m.xc.xt2.msky130_fd_pr__nfet_01v8[vds] @m.xc.xt2.msky130_fd_pr__nfet_01v8[vdsat] @m.xc.xt2.msky130_fd_pr__nfet_01v8[gm] @m.xc.xt2.msky130_fd_pr__nfet_01v8[id] >> op_hi.log
  print @m.xc.xs1.msky130_fd_pr__nfet_01v8[vds] @m.xc.xs1.msky130_fd_pr__nfet_01v8[vdsat] @m.xc.xs1.msky130_fd_pr__nfet_01v8[gm] @m.xc.xs1.msky130_fd_pr__nfet_01v8[id] >> op_hi.log
  print @m.xc.xs2.msky130_fd_pr__nfet_01v8[vds] @m.xc.xs2.msky130_fd_pr__nfet_01v8[vdsat] @m.xc.xs2.msky130_fd_pr__nfet_01v8[gm] @m.xc.xs2.msky130_fd_pr__nfet_01v8[id] >> op_hi.log
  print @m.xc.xmsk.msky130_fd_pr__nfet_01v8[vds] @m.xc.xmsk.msky130_fd_pr__nfet_01v8[vdsat] @m.xc.xmsk.msky130_fd_pr__nfet_01v8[gm] @m.xc.xmsk.msky130_fd_pr__nfet_01v8[id] >> op_hi.log
  print @m.xc.xa1.xm0.msky130_fd_pr__pfet_01v8[vds] @m.xc.xa1.xm0.msky130_fd_pr__pfet_01v8[vdsat] @m.xc.xa1.xm0.msky130_fd_pr__pfet_01v8[gm] @m.xc.xa1.xm0.msky130_fd_pr__pfet_01v8[id] >> op_hi.log
  print @m.xc.xa1.xm1.msky130_fd_pr__pfet_01v8_lvt[vds] @m.xc.xa1.xm1.msky130_fd_pr__pfet_01v8_lvt[vdsat] @m.xc.xa1.xm1.msky130_fd_pr__pfet_01v8_lvt[gm] @m.xc.xa1.xm1.msky130_fd_pr__pfet_01v8_lvt[id] >> op_hi.log
  print @m.xc.xa1.xm2.msky130_fd_pr__pfet_01v8_lvt[vds] @m.xc.xa1.xm2.msky130_fd_pr__pfet_01v8_lvt[vdsat] @m.xc.xa1.xm2.msky130_fd_pr__pfet_01v8_lvt[gm] @m.xc.xa1.xm2.msky130_fd_pr__pfet_01v8_lvt[id] >> op_hi.log
  print @m.xc.xa1.xm3.msky130_fd_pr__nfet_01v8[vds] @m.xc.xa1.xm3.msky130_fd_pr__nfet_01v8[vdsat] @m.xc.xa1.xm3.msky130_fd_pr__nfet_01v8[gm] @m.xc.xa1.xm3.msky130_fd_pr__nfet_01v8[id] >> op_hi.log
  print @m.xc.xa1.xm4.msky130_fd_pr__nfet_01v8[vds] @m.xc.xa1.xm4.msky130_fd_pr__nfet_01v8[vdsat] @m.xc.xa1.xm4.msky130_fd_pr__nfet_01v8[gm] @m.xc.xa1.xm4.msky130_fd_pr__nfet_01v8[id] >> op_hi.log
  print @m.xc.xa1.xm5.msky130_fd_pr__nfet_01v8[vds] @m.xc.xa1.xm5.msky130_fd_pr__nfet_01v8[vdsat] @m.xc.xa1.xm5.msky130_fd_pr__nfet_01v8[gm] @m.xc.xa1.xm5.msky130_fd_pr__nfet_01v8[id] >> op_hi.log
  print @m.xc.xa1.xm6.msky130_fd_pr__nfet_01v8[vds] @m.xc.xa1.xm6.msky130_fd_pr__nfet_01v8[vdsat] @m.xc.xa1.xm6.msky130_fd_pr__nfet_01v8[gm] @m.xc.xa1.xm6.msky130_fd_pr__nfet_01v8[id] >> op_hi.log
  print @m.xc.xa1.xm7.msky130_fd_pr__pfet_01v8[vds] @m.xc.xa1.xm7.msky130_fd_pr__pfet_01v8[vdsat] @m.xc.xa1.xm7.msky130_fd_pr__pfet_01v8[gm] @m.xc.xa1.xm7.msky130_fd_pr__pfet_01v8[id] >> op_hi.log
  print @m.xc.xa1.xm8.msky130_fd_pr__pfet_01v8[vds] @m.xc.xa1.xm8.msky130_fd_pr__pfet_01v8[vdsat] @m.xc.xa1.xm8.msky130_fd_pr__pfet_01v8[gm] @m.xc.xa1.xm8.msky130_fd_pr__pfet_01v8[id] >> op_hi.log
  print @m.xc.xa1.xm9.msky130_fd_pr__pfet_01v8[vds] @m.xc.xa1.xm9.msky130_fd_pr__pfet_01v8[vdsat] @m.xc.xa1.xm9.msky130_fd_pr__pfet_01v8[gm] @m.xc.xa1.xm9.msky130_fd_pr__pfet_01v8[id] >> op_hi.log
  print @m.xc.xa1.xm10.msky130_fd_pr__pfet_01v8[vds] @m.xc.xa1.xm10.msky130_fd_pr__pfet_01v8[vdsat] @m.xc.xa1.xm10.msky130_fd_pr__pfet_01v8[gm] @m.xc.xa1.xm10.msky130_fd_pr__pfet_01v8[id] >> op_hi.log
  print @m.xc.xa2.xm0.msky130_fd_pr__pfet_01v8[vds] @m.xc.xa2.xm0.msky130_fd_pr__pfet_01v8[vdsat] @m.xc.xa2.xm0.msky130_fd_pr__pfet_01v8[gm] @m.xc.xa2.xm0.msky130_fd_pr__pfet_01v8[id] >> op_hi.log
  print @m.xc.xa2.xm1.msky130_fd_pr__pfet_01v8_lvt[vds] @m.xc.xa2.xm1.msky130_fd_pr__pfet_01v8_lvt[vdsat] @m.xc.xa2.xm1.msky130_fd_pr__pfet_01v8_lvt[gm] @m.xc.xa2.xm1.msky130_fd_pr__pfet_01v8_lvt[id] >> op_hi.log
  print @m.xc.xa2.xm2.msky130_fd_pr__pfet_01v8_lvt[vds] @m.xc.xa2.xm2.msky130_fd_pr__pfet_01v8_lvt[vdsat] @m.xc.xa2.xm2.msky130_fd_pr__pfet_01v8_lvt[gm] @m.xc.xa2.xm2.msky130_fd_pr__pfet_01v8_lvt[id] >> op_hi.log
  print @m.xc.xa2.xm3.msky130_fd_pr__nfet_01v8[vds] @m.xc.xa2.xm3.msky130_fd_pr__nfet_01v8[vdsat] @m.xc.xa2.xm3.msky130_fd_pr__nfet_01v8[gm] @m.xc.xa2.xm3.msky130_fd_pr__nfet_01v8[id] >> op_hi.log
  print @m.xc.xa2.xm4.msky130_fd_pr__nfet_01v8[vds] @m.xc.xa2.xm4.msky130_fd_pr__nfet_01v8[vdsat] @m.xc.xa2.xm4.msky130_fd_pr__nfet_01v8[gm] @m.xc.xa2.xm4.msky130_fd_pr__nfet_01v8[id] >> op_hi.log
  print @m.xc.xa2.xm5.msky130_fd_pr__nfet_01v8[vds] @m.xc.xa2.xm5.msky130_fd_pr__nfet_01v8[vdsat] @m.xc.xa2.xm5.msky130_fd_pr__nfet_01v8[gm] @m.xc.xa2.xm5.msky130_fd_pr__nfet_01v8[id] >> op_hi.log
  print @m.xc.xa2.xm6.msky130_fd_pr__nfet_01v8[vds] @m.xc.xa2.xm6.msky130_fd_pr__nfet_01v8[vdsat] @m.xc.xa2.xm6.msky130_fd_pr__nfet_01v8[gm] @m.xc.xa2.xm6.msky130_fd_pr__nfet_01v8[id] >> op_hi.log
  print @m.xc.xa2.xm7.msky130_fd_pr__pfet_01v8[vds] @m.xc.xa2.xm7.msky130_fd_pr__pfet_01v8[vdsat] @m.xc.xa2.xm7.msky130_fd_pr__pfet_01v8[gm] @m.xc.xa2.xm7.msky130_fd_pr__pfet_01v8[id] >> op_hi.log
  print @m.xc.xa2.xm8.msky130_fd_pr__pfet_01v8[vds] @m.xc.xa2.xm8.msky130_fd_pr__pfet_01v8[vdsat] @m.xc.xa2.xm8.msky130_fd_pr__pfet_01v8[gm] @m.xc.xa2.xm8.msky130_fd_pr__pfet_01v8[id] >> op_hi.log
  print @m.xc.xa2.xm9.msky130_fd_pr__pfet_01v8[vds] @m.xc.xa2.xm9.msky130_fd_pr__pfet_01v8[vdsat] @m.xc.xa2.xm9.msky130_fd_pr__pfet_01v8[gm] @m.xc.xa2.xm9.msky130_fd_pr__pfet_01v8[id] >> op_hi.log
  print @m.xc.xa2.xm10.msky130_fd_pr__pfet_01v8[vds] @m.xc.xa2.xm10.msky130_fd_pr__pfet_01v8[vdsat] @m.xc.xa2.xm10.msky130_fd_pr__pfet_01v8[gm] @m.xc.xa2.xm10.msky130_fd_pr__pfet_01v8[id] >> op_hi.log
  alter Vdc dc = 0

  * 2. static transfer: vd from -(half + 0.05) to +(half + 0.05)
  dc Vdc -0.350 0.350 0.002
  let io1 = i(Vo1)
  let io2 = i(Vo2)
  let vs1 = v(s1)
  let vs2 = v(xc.s2)
  let vg1 = v(xc.g1)
  let vg2 = v(xc.g2)
  let vinp = v(inp)
  let vinn = v(inn)
  let idd = -i(VDD)
  wrdata dc_sweep.csv io1 io2 vs1 vs2 vg1 vg2 vinp vinn idd

  * 3. input common-mode sweeps at three differential inputs
  alter Vdc dc = -0.243
  dc Vcm 0.05 1.45 0.01
  let io1 = i(Vo1)
  let io2 = i(Vo2)
  let vs1 = v(s1)
  let vs2 = v(xc.s2)
  let vg1 = v(xc.g1)
  let vg2 = v(xc.g2)
  let vinp = v(inp)
  let vinn = v(inn)
  let idd = -i(VDD)
  wrdata cm_sweep_lo.csv io1 io2 vs1 vs2 vg1 vg2 vinp vinn idd
  alter Vdc dc = 0
  dc Vcm 0.05 1.45 0.01
  let io1 = i(Vo1)
  let io2 = i(Vo2)
  let vs1 = v(s1)
  let vs2 = v(xc.s2)
  let vg1 = v(xc.g1)
  let vg2 = v(xc.g2)
  let vinp = v(inp)
  let vinn = v(inn)
  let idd = -i(VDD)
  wrdata cm_sweep_mid.csv io1 io2 vs1 vs2 vg1 vg2 vinp vinn idd
  alter Vdc dc = 0.243
  dc Vcm 0.05 1.45 0.01
  let io1 = i(Vo1)
  let io2 = i(Vo2)
  let vs1 = v(s1)
  let vs2 = v(xc.s2)
  let vg1 = v(xc.g1)
  let vg2 = v(xc.g2)
  let vinp = v(inp)
  let vinn = v(inn)
  let idd = -i(VDD)
  wrdata cm_sweep_hi.csv io1 io2 vs1 vs2 vg1 vg2 vinp vinn idd
  alter Vdc dc = 0

  * 4. voltage of the regulated nodes (where do T1 and T2 stay saturated?)
  dc Vref2 0.3 1.8 0.01
  let io1 = i(Vo1)
  let io2 = i(Vo2)
  let vs1 = v(s1)
  let vs2 = v(xc.s2)
  let vg1 = v(xc.g1)
  let vg2 = v(xc.g2)
  let vinp = v(inp)
  let vinn = v(inn)
  let idd = -i(VDD)
  wrdata out_sweep.csv io1 io2 vs1 vs2 vg1 vg2 vinp vinn idd
  alter Vref2 dc = 1.55

  * 5. transient with the coherent sine (-0.5 dBFS, 113.28 kHz, 29 periods in 256 us)
  alter Vmode dc = 0
  option reltol=1e-4
  tran 5n 256.0u
  let vdiff = v(inp) - v(inn)
  let io1 = i(Vo1)
  let io2 = i(Vo2)
  wrdata tran_sine.csv vdiff io1 io2

  * 6. transient with large steps (settling): 0 -> +0.8 vd-peak -> -0.8 vd-peak -> 0
  alter Vmode dc = 1
  tran 0.1n 2.6u
  let vdiff = v(inp) - v(inn)
  let io1 = i(Vo1)
  let io2 = i(Vo2)
  let vg1 = v(xc.g1)
  let vs1 = v(s1)
  wrdata tran_step.csv vdiff io1 io2 vg1 vs1

  * 7. loop gain of side 1: open the feedback into OTA 1 (1 GH from s1 to fb1) and feed the test signal in through 1 GF at tst.
  *    T(s) = - v(s1) / v(fb1); v(fb1) is the test signal itself. Mid scale and the two ends of the range.
  alter Vdc dc = 0
  alter Lb1 = 1G
  alter Cb1 = 1G
  op
  ac dec 40 1k 10G
  let lg = -v(s1)
  wrdata ac_loop_mid.csv lg
  alter Vdc dc = -0.243
  op
  ac dec 40 1k 10G
  let lg = -v(s1)
  wrdata ac_loop_lo.csv lg
  alter Vdc dc = 0.243
  op
  ac dec 40 1k 10G
  let lg = -v(s1)
  wrdata ac_loop_hi.csv lg
  alter Lb1 = 1p
  alter Cb1 = 1f
  alter Vdc dc = 0
.endc
.end
